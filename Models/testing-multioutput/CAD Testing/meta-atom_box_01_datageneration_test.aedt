# Ansys Electronics Desktop project, version 2021.2
materials:
  vacuum: permittivity=1
  Rogers RT/duroid 5880 (tm): permittivity=2.2 dielectric_loss_tangent=0.0009
  pec: conductivity=1e+30

design HFSSDesign1 (HFSS, DrivenModal, model units mm)
variables:
  Xsize = 5mm
  Ysize = 5mm
  margin = 1mm
  parameters = [0.2, 0.5, 0.5, 0.5] mm
  H = parameters[3]
geometry:
  Rectangle1 = rectangle(corner=(0mm, 0mm, 0mm), x_size=Xsize, y_size=-Ysize)
  Region [vacuum] = region(absolute_offset: +X=0mm, -X=0mm, +Y=0mm, -Y=0mm, +Z=10mm, -Z=10mm)
  conductor_1..conductor_5 [pec] = imported_body(C:/Users/jorge/Documents/Ansoft/temp/7EF018912170275065088..sm3)
  substrate_11 [Rogers RT/duroid 5880 (tm)] = imported_body(C:/Users/jorge/Documents/Ansoft/temp/7EF018912170275065088..sm3)
boundaries and excitations:
  PerfE1: Perfect E Objects=Rectangle1
  Primary1: Primary Faces=Region.face(+x) CoordSysVector{Region.vertex(1 of 8) -> Region.vertex(2 of 8)}
  Primary2: Primary Faces=Region.face(+y) CoordSysVector{Region.vertex(2 of 8) -> Region.vertex(3 of 8)}
  Secondary1: Secondary Faces=Region.face(-y) CoordSysVector{Region.vertex(1 of 8) -> Region.vertex(4 of 8)} ReverseV primary=Primary2 PhaseDelay=UseScanAngle Phi=0deg Theta=0deg
  Secondary2: Secondary Faces=Region.face(-x) CoordSysVector{Region.vertex(4 of 8) -> Region.vertex(3 of 8)} ReverseV primary=Primary1 PhaseDelay=UseScanAngle Phi=0deg Theta=0deg
  FloquetPort1: Floquet Port Faces=Region.face(+z) NumModes=2 DeembedDist=10mm Modes{Mode1{CharImp=Zpi} Mode2{CharImp=Zpi}} PhaseDelay=UseScanAngle Phi=0deg Theta=0deg LatticeAVector{Region.vertex(1 of 8) -> Region.vertex(2 of 8)} LatticeBVector{Region.vertex(1 of 8) -> Region.vertex(4 of 8)} ModesList{Mode{ModeNumber=1 IndexM=0 IndexN=0 KC2=0 PropagationState=Propagating Attenuation=0 PolarizationState=TE AffectsRefinement} Mode{ModeNumber=2 IndexM=0 IndexN=0 KC2=0 PropagationState=Propagating Attenuation=0 PolarizationState=TM AffectsRefinement}}
  FloquetPort2: Floquet Port Faces=Region.face(-z) NumModes=2 DeembedDist=10mm Modes{Mode1{CharImp=Zpi} Mode2{CharImp=Zpi}} PhaseDelay=UseScanAngle Phi=0deg Theta=0deg LatticeAVector{Region.vertex(6 of 8) -> Region.vertex(5 of 8)} LatticeBVector{Region.vertex(6 of 8) -> Region.vertex(7 of 8)} ModesList{Mode{ModeNumber=1 IndexM=0 IndexN=0 KC2=0 PropagationState=Propagating Attenuation=0 PolarizationState=TE AffectsRefinement} Mode{ModeNumber=2 IndexM=0 IndexN=0 KC2=0 PropagationState=Propagating Attenuation=0 PolarizationState=TM AffectsRefinement}}
setups:
  Setup1: HfssDriven Frequency=60GHz MaxDeltaS=0.02 MaximumPasses=5 MinimumPasses=1 MinimumConvergedPasses=3 PercentRefinement=30 BasisOrder=1 PortAccuracy=2
    sweep Sweep: 30GHz to 90GHz step 0.1GHz; Type=Interpolating InterpTolerance=0.5 InterpMaxSolns=250 InterpUsePortImped=false PassivityErrorTolerance=0.0001
source amplitudes:
  FloquetPort1:1: 1W 0deg
  FloquetPort1:2, FloquetPort2:1, FloquetPort2:2: 0W 0deg
