# Ansys Electronics Desktop project, version 2021.2
materials:
  vacuum: permittivity=1
  Rogers RT/duroid 5880 (tm): permittivity=2.2 dielectric_loss_tangent=0.0009
  pec: conductivity=1e+30
  copper: permeability=0.999991 conductivity=58000000

design HFSSDesign1 (HFSS, DrivenModal, model units mm)
variables:
  Xsize = 4.99048437mm
  Ysize = 4.99048437mm
  H = 0.5mm
  margin = 1mm
geometry:
  Region [vacuum] = region(absolute_offset: +X=0mm, -X=0mm, +Y=0mm, -Y=0mm, +Z=10mm, -Z=10mm)
  Rectangle2 = rectangle(corner=(0mm, 0mm, 0mm), x_size=Xsize, y_size=-Ysize)
  substrate_4 [Rogers RT/duroid 5880 (tm)] = imported_body(C:/Users/jorge/Documents/Ansoft/temp/BFD7984170277174299..sm3)
  substrate_4.thicken(1.75mm)
  conductor_2, conductor_3, conductor_7..conductor_10, conductor_13, conductor_16, conductor_19, conductor_20, conductor_21 [copper] = imported_body(C:/Users/jorge/Documents/Ansoft/temp/1B3410152170300372529..sm3)
  [conductor_2, conductor_3, conductor_7..conductor_10, conductor_13, conductor_16, conductor_19, conductor_20, conductor_21].thicken(0.1mm)
boundaries and excitations:
  Primary1: Primary Faces=Region.face(+x) CoordSysVector{Region.vertex(1 of 8) -> Region.vertex(2 of 8)}
  Primary2: Primary Faces=Region.face(+y) CoordSysVector{Region.vertex(2 of 8) -> Region.vertex(3 of 8)}
  Secondary1: Secondary Faces=Region.face(-y) CoordSysVector{Region.vertex(1 of 8) -> Region.vertex(4 of 8)} ReverseV primary=Primary2 PhaseDelay=UseScanAngle Phi=0deg Theta=0deg
  Secondary2: Secondary Faces=Region.face(-x) CoordSysVector{Region.vertex(4 of 8) -> Region.vertex(3 of 8)} ReverseV primary=Primary1 PhaseDelay=UseScanAngle Phi=0deg Theta=0deg
  PerfE1: Perfect E Objects=Rectangle2
  PerfE2: Perfect E Objects=[conductor_2, conductor_3, conductor_7..conductor_10, conductor_13, conductor_16, conductor_19, conductor_20, conductor_21]
  FloquetPort1: Floquet Port Faces=Region.face(+z) NumModes=2 DeembedDist=10mm Modes{Mode1{CharImp=Zpi} Mode2{CharImp=Zpi}} PhaseDelay=UseScanAngle Phi=0deg Theta=0deg LatticeAVector{Region.vertex(1 of 8) -> Region.vertex(2 of 8)} LatticeBVector{Region.vertex(1 of 8) -> Region.vertex(4 of 8)} ModesList{Mode{ModeNumber=1 IndexM=0 IndexN=0 KC2=0 PropagationState=Propagating Attenuation=0 PolarizationState=TE AffectsRefinement} Mode{ModeNumber=2 IndexM=0 IndexN=0 KC2=0 PropagationState=Propagating Attenuation=0 PolarizationState=TM AffectsRefinement}}
  FloquetPort2: Floquet Port Faces=Region.face(-z) NumModes=2 DeembedDist=10mm Modes{Mode1{CharImp=Zpi} Mode2{CharImp=Zpi}} PhaseDelay=UseScanAngle Phi=0deg Theta=0deg LatticeAVector{Region.vertex(6 of 8) -> Region.vertex(5 of 8)} LatticeBVector{Region.vertex(6 of 8) -> Region.vertex(7 of 8)} ModesList{Mode{ModeNumber=1 IndexM=0 IndexN=0 KC2=0 PropagationState=Propagating Attenuation=0 PolarizationState=TE AffectsRefinement} Mode{ModeNumber=2 IndexM=0 IndexN=0 KC2=0 PropagationState=Propagating Attenuation=0 PolarizationState=TM AffectsRefinement}}
mesh:
  initial mesh: GlobalSurfApproximation{CurvedSurfaceApproxChoice=UseSlider SliderMeshSettings=7} DynamicSurfaceResolution
setups:
  Setup1: HfssDriven Frequency=60GHz MaxDeltaS=0.02 MaximumPasses=10 MinimumPasses=1 MinimumConvergedPasses=1 PercentRefinement=30 BasisOrder=1 PortAccuracy=2
    sweep Sweep: 30GHz to 90GHz step 0.01GHz; Type=Interpolating InterpTolerance=0.5 InterpMaxSolns=250 InterpUsePortImped=false PassivityErrorTolerance=0.0001
source amplitudes:
  FloquetPort1:1: 1W 0deg
  FloquetPort1:2, FloquetPort2:1, FloquetPort2:2: 0W 0deg
output variables:
  transmittance = (mag(S(FloquetPort2:1,FloquetPort1:1)))^2
  transmittanceTM = (mag(S(FloquetPort2:2,FloquetPort1:2)))^2
  ReflectanceTE = (mag(S(FloquetPort1:1,FloquetPort1:1)))^2
  ReflectanceTM = (mag(S(FloquetPort1:2,FloquetPort1:2)))^2
  AbsorbanceTE = 1-((mag(S(FloquetPort1:1,FloquetPort1:1)))^2 +(mag(S(FloquetPort2:1,FloquetPort1:1)))^2)
reports:
  Transmittance: transmittance, transmittanceTM vs Freq on Setup1 : Sweep
  TE: dB(S(FloquetPort1:1,FloquetPort1:1)), dB(S(FloquetPort2:1,FloquetPort1:1)) vs Freq on Setup1 : Sweep
  TM: dB(S(FloquetPort1:2,FloquetPort1:2)), dB(S(FloquetPort2:2,FloquetPort1:2)) vs Freq on Setup1 : Sweep
  Reflectance: ReflectanceTE, ReflectanceTM vs Freq on Setup1 : Sweep
  Absorption: AbsorbanceTE vs Freq on Setup1 : Sweep
